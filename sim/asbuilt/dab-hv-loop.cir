* Ulysses DAB HV bridge exactly as the schematic draws it.
* AH/AL and BH/BL across HV_BUS; the bridge output goes
*   A_SW -> L1 (47 uH) -> current sensor -> B_SW
* and nothing else.  No transformer, no external port.
.param FSW=85000.0
.param TP={1/FSW}

VBUS bus 0 DC 400.0
SAH bus asw ga 0 SWMOD
SAL asw 0   gb 0 SWMOD
SBH bus bsw gb 0 SWMOD
SBL bsw 0   ga 0 SWMOD
* Body diodes -- see the note in link_deck().
DAH asw bus BODY
DAL 0   asw BODY
DBH bsw bus BODY
DBL 0   bsw BODY
.model BODY D(IS=1e-12 RS=0.05 N=1.2 CJO=100p TT=1n BV=800)
VGA ga 0 PULSE(0 5 0 1n 1n {TP/2-4n} {TP})
VGB gb 0 PULSE(0 5 {TP/2} 1n 1n {TP/2-4n} {TP})
.model SWMOD SW(RON=0.12 ROFF=1e9 VT=2.5 VH=0.5)

L1  asw mid 4.7e-05
RL1 mid bsw 0.0427

.control
tran 2.941e-08 0.005 0 uic
meas tran i_pk   max i(l1)  from=0.0045 to=0.005
meas tran i_min  min i(l1)  from=0.0045 to=0.005
meas tran i_rms  rms i(l1)  from=0.0045 to=0.005
meas tran i_bus  avg i(vbus) from=0.0045 to=0.005
print i_pk i_min i_rms i_bus
.endc
.end
