* Ulysses LARS charger - dual active bridge, single phase shift
*
* WHAT THE WHITE PAPER GIVES (page 8): IPB60R120 on the high-voltage bridge,
* BSC190N on the low-voltage bridge with two FETs per branch, a planar
* transformer, UCC27741 gate drivers, phase shift between bridges on TIM1/TIM8.
*
* WHAT IT DOES NOT GIVE, and what DAB power transfer is entirely set by:
* the transformer turns ratio, the leakage inductance, and the switching
* frequency. So this deck does not simulate the white paper's DAB - it cannot.
* It solves the inverse problem instead: given the voltages we do know and a
* chosen frequency, what leakage inductance does the transformer need?
*
* Both bridges are modelled as square-wave sources with the high-voltage side
* referred through the turns ratio, which is the standard reduction of a DAB to
* its power-transfer core. Everything that decides POWER survives it; switching
* loss and ZVS do not, and belong in a deck with real device models once the
* parts are confirmed against datasheets.

.param FS=100k
.param VLV=48
.param VHV=400
.param NT={VHV/VLV}
.param PHIDEG=90
.param LLK=0.96u
.param RLK=8m
.param PI=3.14159265358979
.param TD={PHIDEG/360/FS}

Vlv  p 0 PULSE({-VLV} {VLV} 0 20n 20n {0.5/FS} {1/FS})
Vhv  q 0 PULSE({-VLV} {VLV} {TD} 20n 20n {0.5/FS} {1/FS})
Llk  p m {LLK}
Rlk  m q {RLK}

.control
  set filetype=ascii
  tran 10n 400u 300u
  meas tran il_rms  RMS i(Llk)      FROM=320u TO=400u
  meas tran il_pk   MAX i(Llk)      FROM=320u TO=400u
  let pin = v(p) * i(Llk) * -1
  meas tran p_lv    AVG pin         FROM=320u TO=400u
  let pcu = i(Llk)*i(Llk)*8m
  meas tran p_cu    AVG pcu         FROM=320u TO=400u
  print il_rms il_pk p_lv p_cu
.endc
.end
