* Ulysses LARS charger - series-series compensated resonant link
*
* Source of every component value: the v1 white paper, page 6 (coils, measured)
* and page 5 (rectifier bulk capacitance). The compensation capacitance is NOT
* in the white paper - it only says capacitors are placed in series with the
* coils - so it is computed here for resonance at the drive frequency.
*
* The TX H-bridge is modelled as an ideal +/-VBUS square wave. That is the right
* simplification for the question this deck answers, which is how much power the
* MAGNETICS can move; switching loss and ZVS are a separate deck. It keeps the
* harmonics, so the answer is not a fundamental-only approximation.
*
* Swept by sim/link/run_link.py. Do not edit the .param defaults to run a case -
* pass them on the command line so the run is reproducible from the log.

.param FS=85k
.param VBUS=400
.param LC=12u
.param RC=0.8
.param KC=0.30
.param RLOAD=53.3
.param CB=11u
.param PI=3.14159265358979
.param CS={1/(2*PI*FS*2*PI*FS*LC)}

* ---- transmitter: square-wave bridge into the series-compensated tank -------
Vtx  tx 0 PULSE({-VBUS} {VBUS} 0 20n 20n {0.5/FS} {1/FS})
Cs1  tx  a {CS}
Lp   a   b {LC}
Rp   b   0 {RC}

* ---- the coupled pair -------------------------------------------------------
Ls   c   d {LC}
Rs   d   e {RC}
Cs2  e   f {CS}
K1   Lp  Ls {KC}

* ---- receiver: full-bridge rectifier, bulk capacitor, resistive load --------
* Generic fast rectifier. The white paper names MURSDA860 but gives no ratings
* and the datasheet is not yet in docs/reference/manifest.yaml, so no vendor
* model is claimed here - see the note in docs/design/sim-link.md.
D1   f   out DFAST
D2   c   out DFAST
D3   0   f   DFAST
D4   0   c   DFAST
Cbulk out 0 {CB}
Rload out 0 {RLOAD}
.model DFAST D(IS=5e-9 RS=0.02 N=1.8 BV=1200 CJO=100p TT=25n)

* a DC path for the floating secondary loop, high enough not to load it
Rleak c 0 10meg

.control
  set filetype=ascii
  tran 20n 4m 3m
  meas tran itx_rms  RMS i(Lp)   FROM=3.2m TO=4m
  meas tran irx_rms  RMS i(Ls)   FROM=3.2m TO=4m
  meas tran vout_avg AVG v(out)  FROM=3.2m TO=4m
  meas tran vout_pp  PP  v(out)  FROM=3.2m TO=4m
  meas tran vtank_pk MAX v(a)    FROM=3.2m TO=4m
  print itx_rms irx_rms vout_avg vout_pp vtank_pk
.endc
.end
